** Profile: "SCHEMATIC1-Transient"  [ C:\Users\Andrei\Desktop\proiect_cef2_AAF\Schematics\proiect_cef2_aaf-pspicefiles\schematic1\transient.sim ]

** Creating circuit file "Transient.cir"
** WARNING: THIS AUTOMATICALLY GENERATED FILE MAY BE OVERWRITTEN BY SUBSEQUENT SIMULATIONS

*Libraries:
* Profile Libraries :
* Local Libraries :
.LIB "d:/arhiva facultate/arhiva anul 3/semestrul 1/proiect 1(cef 2)/lib_modelepspice_anexa_1/modele_a1_lib/1n4148.lib"
.LIB "d:/arhiva facultate/arhiva anul 3/semestrul 1/proiect 1(cef 2)/lib_modelepspice_anexa_1/modele_a1_lib/bc846b.lib"
.LIB "d:/arhiva facultate/arhiva anul 3/semestrul 1/proiect 1(cef 2)/lib_modelepspice_anexa_1/modele_a1_lib/bc856b.lib"
* From [PSPICE NETLIST] section of C:\Users\Andrei\AppData\Roaming\SPB_16.6\cdssetup\OrCAD_PSpice\17.2.0\PSpice.ini file:
.lib "nomd.lib"

*Analysis directives:
.TRAN  0 5ms 0 0.01m
.TEMP -10 0 27 50 70 120
.OPTIONS ADVCONV
.PROBE64 V(alias(*)) I(alias(*)) W(alias(*)) D(alias(*)) NOISE(alias(*))
.INC "..\SCHEMATIC1.net"

.END
